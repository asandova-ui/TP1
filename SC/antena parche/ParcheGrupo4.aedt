# Ansys Electronics Desktop project, version 2024.2
materials:
  air: permittivity=1.0006 permeability=1.0000004
  copper: permeability=0.999991 conductivity=58000000
  FR4_epoxy: permittivity=4.4 dielectric_loss_tangent=0.02
  pec: conductivity=1e+30
  vacuum: permittivity=1

design EMDesign1 (HFSS 3D Layout)
ports:
  Port1: Properties{Impedance=50ohm Magnitude=1V Phase=0deg Renormalize_Impedence="50ohm + 0i ohm" Renormalize Deembed_Distance=0mm Deembed Type=Probe HFSS_Type=Gap(coax) Orientation=Horizontal Layer_Alignment=Lower Horizontal_Extent_Factor=5 Vertical_Extent_Factor=3 PEC_Launch_Width=0mm} Type=ProbePort Pin=Port1 Lower{LoadType=CoaxProbe Properties{Lower_Parallel Lower_R=0ohm Lower_L=0nH Lower_C=0pF Lower_Real=0ohm Lower_Imag=0ohm Lower_Magnitude=1V Lower_Phase=0deg Lower_Impedance=50ohm}} Material=copper ViaMesh=Mesh Sides=3
radiation setups:
  DefaultSphere: Type=InfiniteSphereFarField StartTheta=0deg StartPhi=-180deg StopTheta=180deg StopPhi=180deg StepTheta=2deg StepPhi=2deg
  RadiationFieldSphere: Type=InfiniteSphereFarField StartTheta=-180deg StartPhi=0deg StopTheta=180deg StopPhi=90deg StepTheta=2deg StepPhi=90deg
setups:
  PlanarEMSetup1: SolveSetupType=PEM PercentRefinementPerPass=25 MinNumberOfPasses=1 MinNumberOfConvergedPasses=1 Frequency=868MHz MeshSizeFactor=10 ViaNumSides=1 Style25DVia=Wirebond
    sweep Disc_868: 868MHz; GenerateSurfaceCurrent SAbsError=0.005 ZoPercentError=1 PassivityTolerance=0.0001 MaxSolutions=250 InterpUseSMatrix InterpUsePortImpedance InterpUseFullBasis MinSolvedFreq=0.01GHz AutoSMatOnlySolve MinFreqSMatrixOnlySolve=1MHz MagMinThreshold=0.01 InterpMinSolutions=0 FreqSweepType=kDiscrete
    sweep Inter_700_1000: LIN 700MHz 1000MHz 1MHz; SAbsError=0.005 ZoPercentError=1 PassivityTolerance=0.0001 MaxSolutions=250 InterpUseSMatrix InterpUsePortImpedance InterpUseFullBasis MinSolvedFreq=0.01GHz AutoSMatOnlySolve MinFreqSMatrixOnlySolve=1MHz MagMinThreshold=0.01 InterpMinSolutions=0 FreqSweepType=kInterpolating
    sweep Inter_850_900: LIN 850MHz 900MHz 1MHz; SAbsError=0.005 ZoPercentError=1 PassivityTolerance=0.0001 MaxSolutions=250 InterpUseSMatrix InterpUsePortImpedance InterpUseFullBasis MinSolvedFreq=0.01GHz AutoSMatOnlySolve MinFreqSMatrixOnlySolve=1MHz MagMinThreshold=0.01 InterpMinSolutions=0 FreqSweepType=kInterpolating
field plots:
  SurfaceCurrents: J Surf on PlanarEMSetup1 : Disc_868 at Freq=868MHz Phase=0deg
reports:
  S11_dB: dB(S(Port1,Port1)) vs Freq on PlanarEMSetup1 : Inter_700_1000; markers m1 at 0.868GHz
  S11: mag(S(Port1,Port1)) vs Freq on PlanarEMSetup1 : Inter_700_1000; markers m1 at 0.868GHz
  Smith_Chart: S(Port1,Port1) vs Freq on PlanarEMSetup1 : Inter_700_1000
  VSWR_850_900: VSWR(Port1) vs Freq on PlanarEMSetup1 : Inter_850_900; markers m1 at 868MHz
  3DGain: dB(GainInput) vs phi, theta on PlanarEMSetup1 : Disc_868 [Phi=all Theta=all Freq=868MHz]
  2DGain: dB(GainInput) vs theta on PlanarEMSetup1 : Disc_868 [Theta=all Phi=all Freq=868MHz]
  Z Parameter: re(Z(Port1,Port1)), im(Z(Port1,Port1)) vs Freq on PlanarEMSetup1 : Inter_700_1000; markers m1 at 0.868GHz, m2 at 0.868GHz
